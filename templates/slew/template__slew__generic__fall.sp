** SPICE Deck generated by deckgen ***
* DONT_TOUCH_PINS
$HEADER_INFO

* THANOS Headers
* CONSTR_CRITERIA | pushout
* OPT_RESULTS | slew_fall
* MEAS_DEGRADE_PER slew_fall | $PUSHOUT_PER

* SPICE options
.options runlvl=6 ACCURATE=1 BRIEF=1 MODSRH=1 gmindc=1e-15 gdcpath=1e-15 method=gear converge=100 pode_check=0 autostop post=0 NOMOD=1 MEASDGT=7 measform=1 measfile=1 statfl=1 MCBRIEF=5 sampling_method=lhs
.save level=none

* Waveform
.inc '$WAVEFORM_FILE'

* Model include file
.inc '$INCLUDE_FILE'

* Netlist path
.inc '$NETLIST_PATH'

* Library information
.param vdd_value = '$VDD_VALUE'
.param vss_value = 0
.temp $TEMPERATURE

* Slew and load information
.param cl = '$OUTPUT_LOAD'
.param rel_pin_slew = '$INDEX_2_VALUE'

* Voltage
VVDD VDD 0 'vdd_value'
VVSS VSS 0 'vss_value'
VVPP VPP 0 'vdd_value'
VVBB VBB 0 'vss_value'

* Output Load

* Subckt Definition
X1 $NETLIST_PINS $CELL_NAME

* Waveform timestamps
.param max_slew = '$MAX_SLEW'
.param related_pin_t01 = '10 * max_slew'
.param related_pin_t02 = '20 * max_slew'
.param related_pin_t03 = '50 * max_slew'

* Pin definitions
.option ptran_nodeset=1
.nodeset v(Q*) = 'vdd_value'
.nodeset v(QN*) = 'vss_value'
.nodeset v(Z*) = 'vdd_value'
.nodeset v(ZN*) = 'vss_value'
* Toggling pins
XV$REL_PIN $REL_PIN 0 stdvs_fall VDD='vdd_value' slew='rel_pin_slew' t01='related_pin_t01' t02='related_pin_t02' t03='related_pin_t03'

* Measurements
.meas slew_fall trig v($PROBE_PIN_1) val='0.8*vdd_value' fall=1 td='related_pin_t01' targ v($PROBE_PIN_1) val='0.2*vdd_value' fall=1 td='related_pin_t01'

* Transient Sim Command
.tran 1p 50u sweep monte=1

.end
